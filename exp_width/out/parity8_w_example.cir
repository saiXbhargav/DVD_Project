* 8-bit parity checker (28 NAND2) corner 0 Wn=6.251e-08 Wp=1.088e-07
.model  nmos  nmos  level = 54

+version = 4.0             binunit = 1               paramchk= 1               mobmod  = 0
+capmod  = 2               igcmod  = 1               igbmod  = 1               geomod  = 1
+diomod  = 1               rdsmod  = 0               rbodymod= 1               rgatemod= 1
+permod  = 1               acnqsmod= 0               trnqsmod= 0

+tnom    = 27              toxe    = 1.040770329e-09        toxp    = 7e-010          toxm    = 9.5e-010
+dtox    = 2.5e-010        epsrox  = 3.9             wint    = 5e-009          lint    = 1.45e-009
+ll      = 0               wl      = 0               lln     = 1               wln     = 1
+lw      = 0               ww      = 0               lwn     = 1               wwn     = 1
+lwl     = 0               wwl     = 0               xpart   = 0               toxref  = 9.5e-010
+xl	   = -6.5e-9

+vth0    = 0.4438253837         k1      = 0.4             k2      = 0               k3      = 0
+k3b     = 0               w0      = 2.5e-006        dvt0    = 1               dvt1    = 2
+dvt2    = 0               dvt0w   = 0               dvt1w   = 0               dvt2w   = 0
+dsub    = 0.1             minv    = 0.05            voffl   = 0               dvtp0   = 1e-011
+dvtp1   = 0.1             lpe0    = 0               lpeb    = 0               xj      = 5.385001693e-09
+ngate   = 1e+023          ndep    = 6.485165337e+18          nsd     = 2e+020          phin    = 0
+cdsc    = 0               cdscb   = 0               cdscd   = 0               cit     = 0
+voff    = -0.13           nfactor = 2.3             eta0    = 0.0032          etab    = 0
+vfb     = -0.55           u0      = 0.03214272452            ua      = 6e-010          ub      = 1.2e-018
+uc      = 0               vsat    = 290000          a0      = 1               ags     = 0
+a1      = 0               a2      = 1               b0      = 0               b1      = 0
+keta    = 0.04            dwg     = 0               dwb     = 0               pclm    = 0.02
+pdiblc1 = 0.001           pdiblc2 = 0.001           pdiblcb = -0.005          drout   = 0.5
+pvag    = 1e-020          delta   = 0.01            pscbe1  = 8.14e+008       pscbe2  = 1e-007
+fprout  = 0.2             pdits   = 0.01            pditsd  = 0.23            pditsl  = 2300000
+rsh     = 5               rdsw    = 140             rsw     = 75              rdw     = 75
+rdswmin = 0               rdwmin  = 0               rswmin  = 0               prwg    = 0
+prwb    = 0               wr      = 1               alpha0  = 0.074           alpha1  = 0.005
+beta0   = 30              agidl   = 0.0002          bgidl   = 2.1e+009        cgidl   = 0.0002
+egidl   = 0.8             aigbacc = 0.012           bigbacc = 0.0028          cigbacc = 0.002
+nigbacc = 1               aigbinv = 0.014           bigbinv = 0.004           cigbinv = 0.004
+eigbinv = 1.1             nigbinv = 3               aigc    = 0.0213          bigc    = 0.0025889
+cigc    = 0.002           aigsd   = 0.0213          bigsd   = 0.0025889       cigsd   = 0.002
+nigc    = 1               poxedge = 1               pigcd   = 1               ntox    = 1
+xrcrg1  = 12              xrcrg2  = 5

+cgso    = 5e-011          cgdo    = 5e-011          cgbo    = 2.56e-011       cgdl    = 2.653e-010
+cgsl    = 2.653e-010      ckappas = 0.03            ckappad = 0.03            acde    = 1
+moin    = 15              noff    = 0.9             voffcv  = 0.02

+kt1     = -0.11           kt1l    = 0               kt2     = 0.022           ute     = -1.5
+ua1     = 4.31e-009       ub1     = 7.61e-018       uc1     = -5.6e-011       prt     = 0
+at      = 33000

+fnoimod = 1               tnoimod = 0

+jss     = 0.0001          jsws    = 1e-011          jswgs   = 1e-010          njs     = 1
+ijthsfwd= 0.01            ijthsrev= 0.001           bvs     = 10              xjbvs   = 1
+jsd     = 0.0001          jswd    = 1e-011          jswgd   = 1e-010          njd     = 1
+ijthdfwd= 0.01            ijthdrev= 0.001           bvd     = 10              xjbvd   = 1
+pbs     = 1               cjs     = 0.0005          mjs     = 0.5             pbsws   = 1
+cjsws   = 5e-010          mjsws   = 0.33            pbswgs  = 1               cjswgs  = 3e-010
+mjswgs  = 0.33            pbd     = 1               cjd     = 0.0005          mjd     = 0.5
+pbswd   = 1               cjswd   = 5e-010          mjswd   = 0.33            pbswgd  = 1
+cjswgd  = 5e-010          mjswgd  = 0.33            tpb     = 0.005           tcj     = 0.001
+tpbsw   = 0.005           tcjsw   = 0.001           tpbswg  = 0.005           tcjswg  = 0.001
+xtis    = 3               xtid    = 3

+dmcg    = 0               dmci    = 0               dmdg    = 0               dmcgt   = 0
+dwj     = 0               xgw     = 0               xgl     = 0

+rshg    = 0.4             gbmin   = 1e-010          rbpb    = 5               rbpd    = 15
+rbps    = 15              rbdb    = 15              rbsb    = 15              ngcon   = 1

.model  pmos  pmos  level = 54

+version = 4.0             binunit = 1               paramchk= 1               mobmod  = 0
+capmod  = 2               igcmod  = 1               igbmod  = 1               geomod  = 1
+diomod  = 1               rdsmod  = 0               rbodymod= 1               rgatemod= 1
+permod  = 1               acnqsmod= 0               trnqsmod= 0

+tnom    = 27              toxe    = 1.073802642e-09          toxp    = 7e-010          toxm    = 1e-009
+dtox    = 3e-010          epsrox  = 3.9             wint    = 5e-009          lint    = 1.45e-009
+ll      = 0               wl      = 0               lln     = 1               wln     = 1
+lw      = 0               ww      = 0               lwn     = 1               wwn     = 1
+lwl     = 0               wwl     = 0               xpart   = 0               toxref  = 1e-009
+xl	   = -6.5e-9

+vth0    = -0.4646101317        k1      = 0.4             k2      = -0.01           k3      = 0
+k3b     = 0               w0      = 2.5e-006        dvt0    = 1               dvt1    = 2
+dvt2    = -0.032          dvt0w   = 0               dvt1w   = 0               dvt2w   = 0
+dsub    = 0.1             minv    = 0.05            voffl   = 0               dvtp0   = 1e-011
+dvtp1   = 0.05            lpe0    = 0               lpeb    = 0               xj      = 5.239954199e-09
+ngate   = 1e+023          ndep    = 5.129596676e+18        nsd     = 2e+020          phin    = 0
+cdsc    = 0               cdscb   = 0               cdscd   = 0               cit     = 0
+voff    = -0.126          nfactor = 2.1             eta0    = 0.0032          etab    = 0
+vfb     = 0.55            u0      = 0.006336136887           ua      = 2e-009          ub      = 5e-019
+uc      = 0               vsat    = 250000          a0      = 1               ags     = 1e-020
+a1      = 0               a2      = 1               b0      = 0               b1      = 0
+keta    = -0.047          dwg     = 0               dwb     = 0               pclm    = 0.12
+pdiblc1 = 0.001           pdiblc2 = 0.001           pdiblcb = 3.4e-008        drout   = 0.56
+pvag    = 1e-020          delta   = 0.01            pscbe1  = 1.2e+009        pscbe2  = 8.0472e-007
+fprout  = 0.2             pdits   = 0.08            pditsd  = 0.23            pditsl  = 2300000
+rsh     = 5               rdsw    = 140             rsw     = 70              rdw     = 70
+rdswmin = 0               rdwmin  = 0               rswmin  = 0               prwg    = 0
+prwb    = 0               wr      = 1               alpha0  = 0.074           alpha1  = 0.005
+beta0   = 30              agidl   = 0.0002          bgidl   = 2.1e+009        cgidl   = 0.0002
+egidl   = 0.8             aigbacc = 0.012           bigbacc = 0.0028          cigbacc = 0.002
+nigbacc = 1               aigbinv = 0.014           bigbinv = 0.004           cigbinv = 0.004
+eigbinv = 1.1             nigbinv = 3               aigc    = 0.0213          bigc    = 0.0025889
+cigc    = 0.002           aigsd   = 0.0213          bigsd   = 0.0025889       cigsd   = 0.002
+nigc    = 1               poxedge = 1               pigcd   = 1               ntox    = 1
+xrcrg1  = 12              xrcrg2  = 5

+cgso    = 5e-011          cgdo    = 5e-011          cgbo    = 2.56e-011       cgdl    = 2.653e-010
+cgsl    = 2.653e-010      ckappas = 0.03            ckappad = 0.03            acde    = 1
+moin    = 15              noff    = 0.9             voffcv  = 0.02

+kt1     = -0.11           kt1l    = 0               kt2     = 0.022           ute     = -1.5
+ua1     = 4.31e-009       ub1     = 7.61e-018       uc1     = -5.6e-011       prt     = 0
+at      = 33000

+fnoimod = 1               tnoimod = 0

+jss     = 0.0001          jsws    = 1e-011          jswgs   = 1e-010          njs     = 1
+ijthsfwd= 0.01            ijthsrev= 0.001           bvs     = 10              xjbvs   = 1
+jsd     = 0.0001          jswd    = 1e-011          jswgd   = 1e-010          njd     = 1
+ijthdfwd= 0.01            ijthdrev= 0.001           bvd     = 10              xjbvd   = 1
+pbs     = 1               cjs     = 0.0005          mjs     = 0.5             pbsws   = 1
+cjsws   = 5e-010          mjsws   = 0.33            pbswgs  = 1               cjswgs  = 3e-010
+mjswgs  = 0.33            pbd     = 1               cjd     = 0.0005          mjd     = 0.5
+pbswd   = 1               cjswd   = 5e-010          mjswd   = 0.33            pbswgd  = 1
+cjswgd  = 5e-010          mjswgd  = 0.33            tpb     = 0.005           tcj     = 0.001
+tpbsw   = 0.005           tcjsw   = 0.001           tpbswg  = 0.005           tcjswg  = 0.001
+xtis    = 3               xtid    = 3

+dmcg    = 0               dmci    = 0               dmdg    = 0               dmcgt   = 0
+dwj     = 0               xgw     = 0               xgl     = 0

+rshg    = 0.4             gbmin   = 1e-010          rbpb    = 5               rbpd    = 15
+rbps    = 15              rbdb    = 15              rbsb    = 15              ngcon   = 1

.options gmin=1e-18 abstol=1e-18 reltol=1e-6 vntol=1e-9
.temp 83.30009589
Vdd vdd 0 0.985805958
Vss vss 0 0
Vd0 d0 0 0
Vd1 d1 0 0
Vd2 d2 0 0
Vd3 d3 0 0
Vd4 d4 0 0
Vd5 d5 0 0
Vd6 d6 0 0
Vd7 d7 0 0
MPA_x01_g1 x01_n1 d0 vdd vdd pmos W=1.087890732e-07 L=1.6e-08
MPB_x01_g1 x01_n1 d1 vdd vdd pmos W=1.087890732e-07 L=1.6e-08
MNA_x01_g1 x01_n1 d0 x01_g1_x vss nmos W=6.250954636e-08 L=1.6e-08
MNB_x01_g1 x01_g1_x d1 vss vss nmos W=6.250954636e-08 L=1.6e-08
MPA_x01_g2 x01_n2 d0 vdd vdd pmos W=1.087890732e-07 L=1.6e-08
MPB_x01_g2 x01_n2 x01_n1 vdd vdd pmos W=1.087890732e-07 L=1.6e-08
MNA_x01_g2 x01_n2 d0 x01_g2_x vss nmos W=6.250954636e-08 L=1.6e-08
MNB_x01_g2 x01_g2_x x01_n1 vss vss nmos W=6.250954636e-08 L=1.6e-08
MPA_x01_g3 x01_n3 d1 vdd vdd pmos W=1.087890732e-07 L=1.6e-08
MPB_x01_g3 x01_n3 x01_n1 vdd vdd pmos W=1.087890732e-07 L=1.6e-08
MNA_x01_g3 x01_n3 d1 x01_g3_x vss nmos W=6.250954636e-08 L=1.6e-08
MNB_x01_g3 x01_g3_x x01_n1 vss vss nmos W=6.250954636e-08 L=1.6e-08
MPA_x01_g4 x01 x01_n2 vdd vdd pmos W=1.087890732e-07 L=1.6e-08
MPB_x01_g4 x01 x01_n3 vdd vdd pmos W=1.087890732e-07 L=1.6e-08
MNA_x01_g4 x01 x01_n2 x01_g4_x vss nmos W=6.250954636e-08 L=1.6e-08
MNB_x01_g4 x01_g4_x x01_n3 vss vss nmos W=6.250954636e-08 L=1.6e-08
MPA_x23_g1 x23_n1 d2 vdd vdd pmos W=1.087890732e-07 L=1.6e-08
MPB_x23_g1 x23_n1 d3 vdd vdd pmos W=1.087890732e-07 L=1.6e-08
MNA_x23_g1 x23_n1 d2 x23_g1_x vss nmos W=6.250954636e-08 L=1.6e-08
MNB_x23_g1 x23_g1_x d3 vss vss nmos W=6.250954636e-08 L=1.6e-08
MPA_x23_g2 x23_n2 d2 vdd vdd pmos W=1.087890732e-07 L=1.6e-08
MPB_x23_g2 x23_n2 x23_n1 vdd vdd pmos W=1.087890732e-07 L=1.6e-08
MNA_x23_g2 x23_n2 d2 x23_g2_x vss nmos W=6.250954636e-08 L=1.6e-08
MNB_x23_g2 x23_g2_x x23_n1 vss vss nmos W=6.250954636e-08 L=1.6e-08
MPA_x23_g3 x23_n3 d3 vdd vdd pmos W=1.087890732e-07 L=1.6e-08
MPB_x23_g3 x23_n3 x23_n1 vdd vdd pmos W=1.087890732e-07 L=1.6e-08
MNA_x23_g3 x23_n3 d3 x23_g3_x vss nmos W=6.250954636e-08 L=1.6e-08
MNB_x23_g3 x23_g3_x x23_n1 vss vss nmos W=6.250954636e-08 L=1.6e-08
MPA_x23_g4 x23 x23_n2 vdd vdd pmos W=1.087890732e-07 L=1.6e-08
MPB_x23_g4 x23 x23_n3 vdd vdd pmos W=1.087890732e-07 L=1.6e-08
MNA_x23_g4 x23 x23_n2 x23_g4_x vss nmos W=6.250954636e-08 L=1.6e-08
MNB_x23_g4 x23_g4_x x23_n3 vss vss nmos W=6.250954636e-08 L=1.6e-08
MPA_x45_g1 x45_n1 d4 vdd vdd pmos W=1.087890732e-07 L=1.6e-08
MPB_x45_g1 x45_n1 d5 vdd vdd pmos W=1.087890732e-07 L=1.6e-08
MNA_x45_g1 x45_n1 d4 x45_g1_x vss nmos W=6.250954636e-08 L=1.6e-08
MNB_x45_g1 x45_g1_x d5 vss vss nmos W=6.250954636e-08 L=1.6e-08
MPA_x45_g2 x45_n2 d4 vdd vdd pmos W=1.087890732e-07 L=1.6e-08
MPB_x45_g2 x45_n2 x45_n1 vdd vdd pmos W=1.087890732e-07 L=1.6e-08
MNA_x45_g2 x45_n2 d4 x45_g2_x vss nmos W=6.250954636e-08 L=1.6e-08
MNB_x45_g2 x45_g2_x x45_n1 vss vss nmos W=6.250954636e-08 L=1.6e-08
MPA_x45_g3 x45_n3 d5 vdd vdd pmos W=1.087890732e-07 L=1.6e-08
MPB_x45_g3 x45_n3 x45_n1 vdd vdd pmos W=1.087890732e-07 L=1.6e-08
MNA_x45_g3 x45_n3 d5 x45_g3_x vss nmos W=6.250954636e-08 L=1.6e-08
MNB_x45_g3 x45_g3_x x45_n1 vss vss nmos W=6.250954636e-08 L=1.6e-08
MPA_x45_g4 x45 x45_n2 vdd vdd pmos W=1.087890732e-07 L=1.6e-08
MPB_x45_g4 x45 x45_n3 vdd vdd pmos W=1.087890732e-07 L=1.6e-08
MNA_x45_g4 x45 x45_n2 x45_g4_x vss nmos W=6.250954636e-08 L=1.6e-08
MNB_x45_g4 x45_g4_x x45_n3 vss vss nmos W=6.250954636e-08 L=1.6e-08
MPA_x67_g1 x67_n1 d6 vdd vdd pmos W=1.087890732e-07 L=1.6e-08
MPB_x67_g1 x67_n1 d7 vdd vdd pmos W=1.087890732e-07 L=1.6e-08
MNA_x67_g1 x67_n1 d6 x67_g1_x vss nmos W=6.250954636e-08 L=1.6e-08
MNB_x67_g1 x67_g1_x d7 vss vss nmos W=6.250954636e-08 L=1.6e-08
MPA_x67_g2 x67_n2 d6 vdd vdd pmos W=1.087890732e-07 L=1.6e-08
MPB_x67_g2 x67_n2 x67_n1 vdd vdd pmos W=1.087890732e-07 L=1.6e-08
MNA_x67_g2 x67_n2 d6 x67_g2_x vss nmos W=6.250954636e-08 L=1.6e-08
MNB_x67_g2 x67_g2_x x67_n1 vss vss nmos W=6.250954636e-08 L=1.6e-08
MPA_x67_g3 x67_n3 d7 vdd vdd pmos W=1.087890732e-07 L=1.6e-08
MPB_x67_g3 x67_n3 x67_n1 vdd vdd pmos W=1.087890732e-07 L=1.6e-08
MNA_x67_g3 x67_n3 d7 x67_g3_x vss nmos W=6.250954636e-08 L=1.6e-08
MNB_x67_g3 x67_g3_x x67_n1 vss vss nmos W=6.250954636e-08 L=1.6e-08
MPA_x67_g4 x67 x67_n2 vdd vdd pmos W=1.087890732e-07 L=1.6e-08
MPB_x67_g4 x67 x67_n3 vdd vdd pmos W=1.087890732e-07 L=1.6e-08
MNA_x67_g4 x67 x67_n2 x67_g4_x vss nmos W=6.250954636e-08 L=1.6e-08
MNB_x67_g4 x67_g4_x x67_n3 vss vss nmos W=6.250954636e-08 L=1.6e-08
MPA_x0123_g1 x0123_n1 x01 vdd vdd pmos W=1.087890732e-07 L=1.6e-08
MPB_x0123_g1 x0123_n1 x23 vdd vdd pmos W=1.087890732e-07 L=1.6e-08
MNA_x0123_g1 x0123_n1 x01 x0123_g1_x vss nmos W=6.250954636e-08 L=1.6e-08
MNB_x0123_g1 x0123_g1_x x23 vss vss nmos W=6.250954636e-08 L=1.6e-08
MPA_x0123_g2 x0123_n2 x01 vdd vdd pmos W=1.087890732e-07 L=1.6e-08
MPB_x0123_g2 x0123_n2 x0123_n1 vdd vdd pmos W=1.087890732e-07 L=1.6e-08
MNA_x0123_g2 x0123_n2 x01 x0123_g2_x vss nmos W=6.250954636e-08 L=1.6e-08
MNB_x0123_g2 x0123_g2_x x0123_n1 vss vss nmos W=6.250954636e-08 L=1.6e-08
MPA_x0123_g3 x0123_n3 x23 vdd vdd pmos W=1.087890732e-07 L=1.6e-08
MPB_x0123_g3 x0123_n3 x0123_n1 vdd vdd pmos W=1.087890732e-07 L=1.6e-08
MNA_x0123_g3 x0123_n3 x23 x0123_g3_x vss nmos W=6.250954636e-08 L=1.6e-08
MNB_x0123_g3 x0123_g3_x x0123_n1 vss vss nmos W=6.250954636e-08 L=1.6e-08
MPA_x0123_g4 x0123 x0123_n2 vdd vdd pmos W=1.087890732e-07 L=1.6e-08
MPB_x0123_g4 x0123 x0123_n3 vdd vdd pmos W=1.087890732e-07 L=1.6e-08
MNA_x0123_g4 x0123 x0123_n2 x0123_g4_x vss nmos W=6.250954636e-08 L=1.6e-08
MNB_x0123_g4 x0123_g4_x x0123_n3 vss vss nmos W=6.250954636e-08 L=1.6e-08
MPA_x4567_g1 x4567_n1 x45 vdd vdd pmos W=1.087890732e-07 L=1.6e-08
MPB_x4567_g1 x4567_n1 x67 vdd vdd pmos W=1.087890732e-07 L=1.6e-08
MNA_x4567_g1 x4567_n1 x45 x4567_g1_x vss nmos W=6.250954636e-08 L=1.6e-08
MNB_x4567_g1 x4567_g1_x x67 vss vss nmos W=6.250954636e-08 L=1.6e-08
MPA_x4567_g2 x4567_n2 x45 vdd vdd pmos W=1.087890732e-07 L=1.6e-08
MPB_x4567_g2 x4567_n2 x4567_n1 vdd vdd pmos W=1.087890732e-07 L=1.6e-08
MNA_x4567_g2 x4567_n2 x45 x4567_g2_x vss nmos W=6.250954636e-08 L=1.6e-08
MNB_x4567_g2 x4567_g2_x x4567_n1 vss vss nmos W=6.250954636e-08 L=1.6e-08
MPA_x4567_g3 x4567_n3 x67 vdd vdd pmos W=1.087890732e-07 L=1.6e-08
MPB_x4567_g3 x4567_n3 x4567_n1 vdd vdd pmos W=1.087890732e-07 L=1.6e-08
MNA_x4567_g3 x4567_n3 x67 x4567_g3_x vss nmos W=6.250954636e-08 L=1.6e-08
MNB_x4567_g3 x4567_g3_x x4567_n1 vss vss nmos W=6.250954636e-08 L=1.6e-08
MPA_x4567_g4 x4567 x4567_n2 vdd vdd pmos W=1.087890732e-07 L=1.6e-08
MPB_x4567_g4 x4567 x4567_n3 vdd vdd pmos W=1.087890732e-07 L=1.6e-08
MNA_x4567_g4 x4567 x4567_n2 x4567_g4_x vss nmos W=6.250954636e-08 L=1.6e-08
MNB_x4567_g4 x4567_g4_x x4567_n3 vss vss nmos W=6.250954636e-08 L=1.6e-08
MPA_p_g1 p_n1 x0123 vdd vdd pmos W=1.087890732e-07 L=1.6e-08
MPB_p_g1 p_n1 x4567 vdd vdd pmos W=1.087890732e-07 L=1.6e-08
MNA_p_g1 p_n1 x0123 p_g1_x vss nmos W=6.250954636e-08 L=1.6e-08
MNB_p_g1 p_g1_x x4567 vss vss nmos W=6.250954636e-08 L=1.6e-08
MPA_p_g2 p_n2 x0123 vdd vdd pmos W=1.087890732e-07 L=1.6e-08
MPB_p_g2 p_n2 p_n1 vdd vdd pmos W=1.087890732e-07 L=1.6e-08
MNA_p_g2 p_n2 x0123 p_g2_x vss nmos W=6.250954636e-08 L=1.6e-08
MNB_p_g2 p_g2_x p_n1 vss vss nmos W=6.250954636e-08 L=1.6e-08
MPA_p_g3 p_n3 x4567 vdd vdd pmos W=1.087890732e-07 L=1.6e-08
MPB_p_g3 p_n3 p_n1 vdd vdd pmos W=1.087890732e-07 L=1.6e-08
MNA_p_g3 p_n3 x4567 p_g3_x vss nmos W=6.250954636e-08 L=1.6e-08
MNB_p_g3 p_g3_x p_n1 vss vss nmos W=6.250954636e-08 L=1.6e-08
MPA_p_g4 p p_n2 vdd vdd pmos W=1.087890732e-07 L=1.6e-08
MPB_p_g4 p p_n3 vdd vdd pmos W=1.087890732e-07 L=1.6e-08
MNA_p_g4 p p_n2 p_g4_x vss nmos W=6.250954636e-08 L=1.6e-08
MNB_p_g4 p_g4_x p_n3 vss vss nmos W=6.250954636e-08 L=1.6e-08
.op
.end
